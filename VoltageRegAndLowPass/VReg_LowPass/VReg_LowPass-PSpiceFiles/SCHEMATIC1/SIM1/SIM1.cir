** Profile: "SCHEMATIC1-SIM1"  [ c:\users\logan\desktop\ee318project\voltageregandlowpass\vreg_lowpass\vreg_lowpass-pspicefiles\schematic1\sim1.sim ]

** Creating circuit file "SIM1.cir"
** WARNING: THIS AUTOMATICALLY GENERATED FILE MAY BE OVERWRITTEN BY SUBSEQUENT SIMULATIONS

*Libraries:
* Profile Libraries :
* Local Libraries :
* From [PSPICE NETLIST] section of C:\cds_spb_home\cdssetup\OrCAD_PSpiceTIPSpice_Install\23.1.0\PSpice.ini file:
.lib "nom_pspti.lib"
.lib "nom.lib"

*Analysis directives:
.TRAN  0 1000ns 0
.OPTIONS ADVCONV
.OPTIONS FILEMODELSEARCH
.PROBE64 V(alias(*)) I(alias(*)) W(alias(*)) D(alias(*)) NOISE(alias(*))
.INC "..\SCHEMATIC1.net"

.END
